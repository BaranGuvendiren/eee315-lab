* /Users/baranguvendiren/workshop/university/labs/eee315-lab/experiment-1/experiment-1.asc
* Generated by LTspice 26.0.2 for MacOS.
Vin IN 0 PULSE(-5 5 0 5m 5m 0 10m)
R1 IN OUT 1k
D2 OUT N002 1N4007d
D1 N001 OUT 1N4007d
R2 N001 0 470
R3 N002 N003 1k
V1 N003 0 2
.model D D
.lib C:\users\crossover\AppData\Local\LTspice\lib\cmp\standard.dio
.tran 10m
.model 1N4007d D(Is=7.028e-09 Rs=0.0348 N=1.808 Eg=1.05743 Xti=5 BV=1000
+ Ibv=5e-08 Cjo=1e-11 Vj=0.7 M=0.5 Fc=0.5 Tt=1e-07 Kf=0 Af=1)
.backanno
.end
